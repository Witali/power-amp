* sine check
.options abstol=1n reltol=0.003 itl1=500 itl4=500
VCC vcc 0 12
VIN vin 0 DC 0 SIN(0 0.03 1000)
R4 vin 0 470k
C3 vin b_in 10u
R3 b_in 0 1k
R2 drive b_in 7047.386
Q1 drive b_in 0 KT3102A
R1 vcc b_top 2369.293
D1 b_top d_mid KD521A
D2 d_mid drive KD521A
Q2 vcc b_top out KT817A
Q3 0 drive out KT816A
C2 out load 1000u
RLOAD load 0 8
C1 vcc 0 1000u

.model KD521A D(Is=2.5n Rs=1.8 N=1.85 Cjo=2p M=0.33 Bv=75 Ibv=5u Tt=4n)
.model KT3102A NPN(Is=2e-14 Bf=100 Br=6 Vaf=100 Var=20 Ikf=0.12 Ikr=0.02 Rc=1 Re=0.35 Rb=60 Cje=9p Cjc=4p Tf=0.4n Tr=35n)
.model KT817A NPN(Is=9e-14 Bf=50 Br=5 Vaf=70 Var=15 Ikf=3.0 Ikr=0.4 Rc=0.12 Re=0.06 Rb=2.5 Cje=140p Cjc=80p Tf=0.45u Tr=6u)
.model KT816A PNP(Is=1.1e-13 Bf=50 Br=5 Vaf=60 Var=15 Ikf=2.5 Ikr=0.35 Rc=0.14 Re=0.07 Rb=2.8 Cje=160p Cjc=90p Tf=0.55u Tr=7u)

.control
tran 1.953125e-06 0.024 0.012 1.953125e-06
wrdata sine_30p000mv.csv time v(vin) v(load) v(out)
quit
.endc
.end
