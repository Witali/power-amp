* Reconstructed RadioStorage shema-1804-6 single-supply BJT audio amplifier
* Original image: https://radiostorage.net/uploads/Image/schemes/18/shema-1804-6.png
* Load changed from the image's 4 ohm speaker to user's requested 8 ohm speaker.
* This tuned model uses Bf=100 for the input transistor and Bf=50 for the
* output transistors. R1/R2 are tuned for about 10 mA output-stage idle
* current and for the output emitter node to sit near half supply.

.options abstol=1n reltol=0.003 itl1=500 itl4=500
.temp 27

VCC vcc 0 12
VIN vin 0 DC 0 AC 1 SIN(0 1m 1k)

* Input potentiometer/load and coupling capacitor
R4 vin 0 470k
C3 vin b_in 10u
R3 b_in 0 10k

* Feedback and voltage-amplifier transistor
R2 out b_in 6.8k
Q1 drive b_in 0 KT3102A

* Bias chain and complementary emitter follower
R1 vcc b_top 2.4k
D1 b_top d_mid KD521A
D2 d_mid drive KD521A
Q2 vcc b_top out KT817A
Q3 0 drive out KT816A

* Output coupling capacitor and speaker
C2 out load 4700u
RLOAD load 0 8
C1 vcc 0 1000u

.model KD521A D(Is=2.5n Rs=1.8 N=1.85 Cjo=2p M=0.33 Bv=75 Ibv=5u Tt=4n)
.model KT3102A NPN(Is=2e-14 Bf=100 Br=6 Vaf=100 Var=20 Ikf=0.12 Ikr=0.02
+ Rc=1 Re=0.35 Rb=60 Cje=9p Cjc=4p Tf=0.4n Tr=35n)
.model KT817A NPN(Is=9e-14 Bf=50 Br=5 Vaf=70 Var=15 Ikf=3.0 Ikr=0.4
+ Rc=0.12 Re=0.06 Rb=2.5 Cje=140p Cjc=80p Tf=0.45u Tr=6u)
.model KT816A PNP(Is=1.1e-13 Bf=50 Br=5 Vaf=60 Var=15 Ikf=2.5 Ikr=0.35
+ Rc=0.14 Re=0.07 Rb=2.8 Cje=160p Cjc=90p Tf=0.55u Tr=7u)

.control
set noaskquit
op
print v(b_in) v(drive) v(b_top) v(out) v(load)
print i(vcc)
print @q1[ic] @q2[ic] @q3[ic]
ac dec 80 5 200k
wrdata ../data/ac_response.csv frequency vdb(load) vp(load)
tran 5u 60m 40m
wrdata ../data/transient_1khz.csv time v(vin) v(b_in) v(out) v(load)
quit
.endc

.end
